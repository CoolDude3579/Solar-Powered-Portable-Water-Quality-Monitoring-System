* Li-ion 3.7 V -> 5.0 V boost converter with PI control and load step
Vbat bat 0 {Vin}
Rdcr bat lx 0.05
L1 lx sw 10u
D1 sw out SS14
Resr out cx 0.15
Cout cx 0 220u
Rload out 0 {Rl}
Vramp ramp 0 PULSE(0.03 1 0 1.99u 5n 0 2u)
* Output capacitor: 220 uF electrolytic, its 0.15 ohm ESR damps the LC resonance
* Power MOSFET as a switch, driven by the PWM comparator below (500 kHz)
S1 sw 0 duty ramp NSW
.model NSW SW(Ron=0.06 Roff=1Meg Vt=0 Vh=0.01)
.model SS14 D(Is=5u Rs=0.04 N=1.05 Cjo=110p)
* PI controller: integrator node 'integ' + proportional term, duty clamped 0..0.85
* Feedback low-pass filter (removes switching ripple before the controller)
Rf out fb 1k
Cf fb 0 10n
* Soft-start reference: ramps from the battery voltage up to 5.0 V over 1 ms
Vref ref 0 PWL(0 {Vin} 1m 5.0)
* Integral control (~500 Hz crossover) with anti-windup: integrator stops at 0 and 0.85 duty
Bint 0 integ I=0.5u*( max(V(ref)-V(fb),0)*min(1,max(0,(0.85-V(integ))*50)) + min(V(ref)-V(fb),0)*min(1,max(0,V(integ)*50)) )
Cint integ 0 1n
Rleak integ 0 1G
Bduty dutyr 0 V=min(0.85, max(0, V(integ)))
Rd dutyr duty 100
Cd duty 0 100p
* PWM comparator is built into S1: switch closes while V(duty) > V(ramp) (0-1 V sawtooth)
.param Vin=3.7 Rl=20
.ic V(integ)=0.1 V(out)=3.4 V(cx)=3.4 V(fb)=3.4
* Load step: extra 250 mA (ESP32 WiFi transmit burst) at 3.5 ms on top of the 250 mA base
Sload out lstep lctl 0 NSW
Rstep lstep 0 20
Vlctl lctl 0 PULSE(-1 1 3.5m 1u 1u 10 20)
.meas TRAN Vout_avg AVG V(out) FROM=3m TO=3.5m
.meas TRAN Vout_ripple PP V(out) FROM=3m TO=3.5m
.meas TRAN Vout_min_on_step MIN V(out) FROM=3.5m TO=4.5m
.meas TRAN Vout_after_step AVG V(out) FROM=5.5m TO=6m
.meas TRAN Iin_avg AVG I(Vbat) FROM=3m TO=3.5m
.tran 10n 6m 0 20n uic
.end
